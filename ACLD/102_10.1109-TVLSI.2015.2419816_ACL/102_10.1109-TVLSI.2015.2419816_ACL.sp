// Design: SCLCell045/testing
simulator lang=spectre
global 0
include "/home/yongfu/research-freepdk-library/Cadence45/TECH/GPDK045/gpdk045_v_6_0/gpdk045/../models/spectre/gpdk045.scs" section=mc

// SCLCell045/TH12X1/schematic
subckt TH12X1 VDD VSS a b q s
    NM5 (q s VSS VSS) g45n1svt w=(260n) l=45n nf=1 m=(1)
    NM4 (q net02 VSS VSS) g45n1svt w=(260n) l=45n nf=1 m=(1)
    NM1 (net02 a VSS VSS) g45n1svt w=(260n) l=45n nf=1 m=(1)
    NM0 (net02 b VSS VSS) g45n1svt w=(260n) l=45n nf=1 m=(1)
    PM5 (net30 s VDD VDD) g45p1svt w=(390n) l=45n nf=1 m=(1)
    PM4 (q net02 net30 VDD) g45p1svt w=(390n) l=45n nf=1 m=(1)
    mp0 (net02 a net07 VDD) g45p1svt w=(390n) l=45n nf=1 m=(1)
    PM0 (net07 b VDD VDD) g45p1svt w=(390n) l=45n nf=1 m=(1)
ends TH12X1

// SCLCell045/testing/schematic
I1 (net1 net2 net4 net5 net3 net6) TH12X1
simulatorOptions options temp=27
