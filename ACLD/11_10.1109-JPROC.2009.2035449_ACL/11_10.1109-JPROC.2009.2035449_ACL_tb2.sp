// Design: AscendNCLCell/testing
simulator lang=spectre
global 0
include "/home/yongfu/research-freepdk-library/Cadence45/TECH/GPDK045/gpdk045_v_6_0/gpdk045/../models/spectre/gpdk045.scs" section=mc

// AscendNCLCell/INCL2W11OF2X1/schematic
subckt INCL2W11OF2X1 a b q VDD VSS
    MPO0 (VDD IQ q VDD) g45p1svt w=390.00n l=45n ld=105n ls=105n m=1
    MPI1 (pl00 b PREQ VDD) g45p1svt w=390.0n l=45n ld=105n ls=105n m=1
    MPI0 (VDD a pl00 VDD) g45p1svt w=390.0n l=45n ld=105n ls=105n m=1
    MPB0 (VDD PREQ IQ VDD) g45p1svt w=390.00n l=45n ld=105n ls=105n m=1
    MPH0 (PREQ IQ ph00 VDD) g45p1svt w=390.0n l=45n ld=105n ls=105n m=1
    MPH1 (ph00 a VDD VDD) g45p1svt w=390.0n l=45n ld=105n ls=105n m=1
    MPH2 (ph00 b VDD VDD) g45p1svt w=390.0n l=45n ld=105n ls=105n m=1
    MNI0 (PREQ b nl00 VSS) g45n1svt w=260.0n l=45n ld=105n ls=105n m=1
    MNI1 (nl00 a VSS VSS) g45n1svt w=260.0n l=45n ld=105n ls=105n m=1
    MNO0 (q IQ VSS VSS) g45n1svt w=260.00n l=45n ld=105n ls=105n m=1
    MNH1 (VSS a nh00 VSS) g45n1svt w=260.0n l=45n ld=105n ls=105n m=1
    MNH2 (VSS b nh00 VSS) g45n1svt w=260.0n l=45n ld=105n ls=105n m=1
    MNH0 (nh00 IQ PREQ VSS) g45n1svt w=260.0n l=45n ld=105n ls=105n m=1
    MNB0 (IQ PREQ VSS VSS) g45n1svt w=260.00n l=45n ld=105n ls=105n m=1
ends INCL2W11OF2X1

// AscendNCLCell/tb_INCL2W11OF2X1/schematic
V5 (VSS 0) vsource dc=0 type=dc
V1 (VDD VSS) vsource dc=vdd type=dc
V4 (a VSS) vsource dc=0 type=pulse val0=0 val1=0 period=100n delay=10n rise=100.0p fall=100.0p
V0 (b VSS) vsource dc=0 type=pulse val0=0 val1=0 period=500n delay=10n rise=100.0p fall=100.0p
I2 (a b q) INCL2W11OF2X1
simulatorOptions options temp=27
