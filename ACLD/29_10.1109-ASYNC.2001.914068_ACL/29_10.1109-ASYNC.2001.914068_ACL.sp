// Design: GASPCell045/testing
simulator lang=spectre
global 0
include "/home/yongfu/research-freepdk-library/Cadence45/TECH/GPDK045/gpdk045_v_6_0/gpdk045/../models/spectre/gpdk045.scs" section=mc

// gsclib045u/INVX1/schematic
subckt gsclib045u_INVX1_schematic A Y inh_VDD inh_VSS
    mp0 (Y A inh_VDD inh_VDD) g45p1svt w=(390n) l=45n nf=1 m=(1)
    mn0 (Y A inh_VSS inh_VSS) g45n1svt w=(260n) l=45n nf=1 m=(1)
ends gsclib045u_INVX1_schematic

// GASPCell045/GASPLATCHX1/schematic
subckt GASPLATCHX1 VDD VSS data_in data_out
    I4 (net2 data_in VDD VSS) gsclib045u_INVX1_schematic
    I3 (net2 data_out VDD VSS) gsclib045u_INVX1_schematic
    I2 (net2 data_out VDD VSS) gsclib045u_INVX1_schematic
    I1 (data_in net2 VDD VSS) gsclib045u_INVX1_schematic
    I0 (data_in net2 VDD VSS) gsclib045u_INVX1_schematic
ends GASPLATCHX1

// GASPCell045/testing/schematic
I2 (net1 net2 net4 net3) GASPLATCHX1
simulatorOptions options temp=27
