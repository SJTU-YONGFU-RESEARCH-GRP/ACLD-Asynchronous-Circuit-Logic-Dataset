// Design: LCLCell045/testing
simulator lang=spectre
global 0
include "/home/yongfu/research-freepdk-library/Cadence45/TECH/GPDK045/gpdk045_v_6_0/gpdk045/../models/spectre/gpdk045.scs" section=mc

// LCLCell045/LCL1W11OF2X1/schematic
subckt LCL1W11OF2X1 A B Q VDD VSS
    M_i_5 (Q Q_neg VSS VSS) g45n1svt w=260.00n l=45n ld=105n ls=105n m=1
    M_i_1 (Q_neg B VSS VSS) g45n1svt w=260.00n l=45n ld=105n ls=105n m=1
    M_i_0 (VSS A Q_neg VSS) g45n1svt w=260.00n l=45n ld=105n ls=105n m=1
    M_i_4 (Q Q_neg VDD VDD) g45p1svt w=390.00n l=45n ld=105n ls=105n m=1
    M_i_3 (net_0 B VDD VDD) g45p1svt w=390.0n l=45n ld=105n ls=105n m=1
    M_i_2 (Q_neg A net_0 VDD) g45p1svt w=390.0n l=45n ld=105n ls=105n m=1
ends LCL1W11OF2X1

// LCLCell045/tb_LCL1W11OF2X1/schematic
I7 (A B Q VDD VSS) LCL1W11OF2X1
V5 (VSS 0) vsource dc=0 type=dc
V1 (VDD VSS) vsource dc=vdd type=dc
V4 (B VSS) vsource dc=0 type=pulse val0=0 val1=0 period=50n delay=10n rise=100.0p fall=100.0p
V0 (A VSS) vsource dc=0 type=pulse val0=0 val1=0 period=100n delay=10n rise=100.0p fall=100.0p
simulatorOptions options temp=27
tran tran stop=200n errpreset=moderate
dcOp dc
