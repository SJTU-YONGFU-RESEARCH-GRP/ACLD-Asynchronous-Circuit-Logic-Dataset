// Design: LCLCell045/testing
simulator lang=spectre
global 0
include "../../../input/spectre/gpdk045.scs" section=mc

// LCLCell045/LCL1W11OF2X1/schematic
subckt LCL1W11OF2X1 A B Q VDD VSS
    M_i_5 (Q Q_neg VSS VSS) g45n1svt w=260.00n l=45n ld=105n ls=105n m=1
    M_i_1 (Q_neg B VSS VSS) g45n1svt w=260.00n l=45n ld=105n ls=105n m=1
    M_i_0 (VSS A Q_neg VSS) g45n1svt w=260.00n l=45n ld=105n ls=105n m=1
    M_i_4 (Q Q_neg VDD VDD) g45p1svt w=390.00n l=45n ld=105n ls=105n m=1
    M_i_3 (net_0 B VDD VDD) g45p1svt w=390.0n l=45n ld=105n ls=105n m=1
    M_i_2 (Q_neg A net_0 VDD) g45p1svt w=390.0n l=45n ld=105n ls=105n m=1
ends LCL1W11OF2X1

// LCLCell045/testing/schematic
I4 (net4 net5 net3 net1 net2) LCL1W11OF2X1
simulatorOptions options temp=27
