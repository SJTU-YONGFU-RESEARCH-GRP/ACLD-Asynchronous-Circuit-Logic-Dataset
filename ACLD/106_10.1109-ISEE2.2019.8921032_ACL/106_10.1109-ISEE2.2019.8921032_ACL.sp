// Design: LCLCell045/testing
simulator lang=spectre
global 0
include "/home/yongfu/research-freepdk-library/Cadence45/TECH/GPDK045/gpdk045_v_6_0/gpdk045/../models/spectre/gpdk045.scs" section=mc

// LCLCell045/LCL1W1OF1X1/schematic
subckt LCL1W1OF1X1 A Q VDD VSS
    MPO0 (VDD PREQ Q VDD) g45p1svt w=390.00n l=45n ld=105n ls=105n m=1
    MPI0 (VDD A PREQ VDD) g45p1svt w=390.00n l=45n ld=105n ls=105n m=1
    MNO0 (Q PREQ VSS VSS) g45n1svt w=260.00n l=45n ld=105n ls=105n m=1
    MNI0 (PREQ A VSS VSS) g45n1svt w=260.00n l=45n ld=105n ls=105n m=1
ends LCL1W1OF1X1

// LCLCell045/testing/schematic
I1 (net4 net3 net1 net2) LCL1W1OF1X1
simulatorOptions options temp=27
