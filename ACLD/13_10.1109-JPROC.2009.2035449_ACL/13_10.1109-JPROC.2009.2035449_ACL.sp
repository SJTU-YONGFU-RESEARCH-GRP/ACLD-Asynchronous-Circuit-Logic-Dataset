/ Generated for: spectre
// Design: AscendNCLCell/testing
simulator lang=spectre
global 0
include "../../../input/spectre/gpdk045.scs" section=mc

// AscendNCLCell/INCL1W1OF1X1/schematic
subckt INCL1W1OF1X1 a q VDD VSS
    MPO0 (VDD a q VDD) g45p1svt w=(390n) l=45n nf=1 m=(1)
    MNO0 (q a VSS VSS) g45n1svt w=(260n) l=45n nf=1 m=(1)
ends INCL1W1OF1X1

// AscendNCLCell/testing/schematic
I7 (net2 net1) INCL1W1OF1X1
simulatorOptions options temp=27
