/ Generated for: spectre
// Design: AscendNCLCell/testing
simulator lang=spectre
global 0
include "/home/yongfu/research-freepdk-library/Cadence45/TECH/GPDK045/gpdk045_v_6_0/gpdk045/../models/spectre/gpdk045.scs" section=mc

// AscendNCLCell/INCL1W1OF1X1/schematic
subckt INCL1W1OF1X1 a q VDD VSS
    MPO0 (VDD a q VDD) g45p1svt w=390n l=45n ld=105n ls=105n m=1
    MNO0 (q a VSS VSS) g45n1svt w=260.00n l=45n ld=105n ls=105n m=1
ends INCL1W1OF1X1

// AscendNCLCell/testing/schematic
I7 (net2 net1) INCL1W1OF1X1
simulatorOptions options temp=27
