// Design: AscendNCLCell/testing
simulator lang=spectre
global 0
include "/home/yongfu/research-freepdk-library/Cadence45/TECH/GPDK045/gpdk045_v_6_0/gpdk045/../models/spectre/gpdk045.scs" section=mc

// AscendNCLCell/NCL1W111OF3X1/schematic
subckt NCL1W111OF3X1 a b c q VDD VSS
    MPI0 (VDD a pl00 VDD) g45p1svt w=3.05e-07 l=5e-08 ld=105n ls=105n m=1
    MPI2 (pl01 c PREQ VDD) g45p1svt w=3.05e-07 l=5e-08 ld=105n ls=105n m=1
    MPI1 (pl00 b pl01 VDD) g45p1svt w=3.05e-07 l=5e-08 ld=105n ls=105n m=1
    MPO0 (VDD PREQ q VDD) g45p1svt w=2.05e-07 l=5e-08 ld=105n ls=105n m=1
    MNI0 (PREQ a VSS VSS) g45n1svt w=1.15e-07 l=5e-08 ld=105n ls=105n m=1
    MNI1 (PREQ b VSS VSS) g45n1svt w=1.15e-07 l=5e-08 ld=105n ls=105n m=1
    MNI2 (PREQ c VSS VSS) g45n1svt w=1.15e-07 l=5e-08 ld=105n ls=105n m=1
    MNO0 (q PREQ VSS VSS) g45n1svt w=1.55e-07 l=5e-08 ld=105n ls=105n m=1
ends NCL1W111OF3X1

// AscendNCLCell/testing/schematic
I3 (net4 net3 net2 net1) NCL1W111OF3X1
simulatorOptions options temp=27
