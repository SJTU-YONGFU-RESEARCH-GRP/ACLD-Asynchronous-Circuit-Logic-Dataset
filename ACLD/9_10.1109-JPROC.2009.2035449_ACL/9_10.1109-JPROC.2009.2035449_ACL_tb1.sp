// Design: AscendNCLCell/testing
simulator lang=spectre
global 0
include "/home/yongfu/research-freepdk-library/Cadence45/TECH/GPDK045/gpdk045_v_6_0/gpdk045/../models/spectre/gpdk045.scs" section=mc

// AscendNCLCell/NCL1W1OF1X1/schematic
subckt NCL1W1OF1X1 a q VDD VSS
    MPI0 (VDD a PREQ VDD) g45p1svt w=390.00n l=45n ld=105n ls=105n m=1
    MPO0 (VDD PREQ q VDD) g45p1svt w=390.00n l=45n ld=105n ls=105n m=1
    MNI0 (PREQ a VSS VSS) NMOS_VTL w=260.00n l=45n ld=105n ls=105n m=1
    MNO0 (q PREQ VSS VSS) NMOS_VTL w=260.00n l=45n ld=105n ls=105n m=1
ends NCL1W1OF1X1

// AscendNCLCell/tb_NCL1W1OF1X1/schematic
I2 (a q) NCL1W1OF1X1
V5 (VSS 0) vsource dc=0 type=dc
V1 (VDD VSS) vsource dc=vdd type=dc
V4 (a VSS) vsource dc=0 type=pulse val0=0 val1=1.2 period=100n delay=10n rise=100.0p fall=100.0p
simulatorOptions options temp=27
tran tran stop=200n errpreset=moderate
dcOp dc
