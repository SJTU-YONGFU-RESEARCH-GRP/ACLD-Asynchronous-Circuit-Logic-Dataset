// Design: SAPTLCell045/testing
simulator lang=spectre
global 0
include "/home/yongfu/research-freepdk-library/Cadence45/TECH/GPDK045/gpdk045_v_6_0/gpdk045/../models/spectre/gpdk045.scs" section=mc

// gsclib045u/INVX1/schematic
subckt gsclib045u_INVX1_schematic A Y inh_VDD inh_VSS
    mp0 (Y A inh_VDD inh_VDD) g45p1svt w=(390n) l=45n nf=1 m=(1)
    mn0 (Y A inh_VSS inh_VSS) g45n1svt w=(260n) l=45n nf=1 m=(1)
ends gsclib045u_INVX1_schematic

// gsclib045u/CELEMENTX1/schematic
subckt CELEMENTX1 A B C VDD VSS
    I1 (C net1 VDD VSS) gsclib045u_INVX1_schematic
    I0 (net1 C VDD VSS) gsclib045u_INVX1_schematic
    NM0 (net09 A VSS VSS) g45n1svt w=(260n) l=45n nf=1 m=(1)
    mn0 (net1 B net09 VSS) g45n1svt w=(260n) l=45n nf=1 m=(1)
    PM0 (net012 A VDD VDD) g45p1svt w=(390n) l=45n nf=1 m=(1)
    mp0 (net1 B net012 VDD) g45p1svt w=(390n) l=45n nf=1 m=(1)
ends CELEMENTX1

// Design: SCLCell045/testing
simulator lang=spectre
global 0
include "/home/yongfu/research-freepdk-library/Cadence45/TECH/GPDK045/gpdk045_v_6_0/gpdk045/../models/spectre/gpdk045.scs" section=mc

// SCLCell045/TH23X1/schematic
subckt TH23X1 VDD VSS a b c q s
    NM5 (q s VSS VSS) g45n1svt w=(260n) l=45n nf=1 m=(1)
    NM4 (q net02 VSS VSS) g45n1svt w=(260n) l=45n nf=1 m=(1)
    NM3 (net26 c VSS VSS) g45n1svt w=(260n) l=45n nf=1 m=(1)
    NM2 (net02 b net26 VSS) g45n1svt w=(260n) l=45n nf=1 m=(1)
    NM1 (net013 c VSS VSS) g45n1svt w=(260n) l=45n nf=1 m=(1)
    NM0 (net013 b VSS VSS) g45n1svt w=(260n) l=45n nf=1 m=(1)
    mn0 (net02 a net013 VSS) g45n1svt w=(260n) l=45n nf=1 m=(1)
    PM5 (net30 s VDD VDD) g45p1svt w=(390n) l=45n nf=1 m=(1)
    PM4 (q net02 net30 VDD) g45p1svt w=(390n) l=45n nf=1 m=(1)
    PM3 (net20 c VDD VDD) g45p1svt w=(390n) l=45n nf=1 m=(1)
    PM2 (net02 a net20 VDD) g45p1svt w=(390n) l=45n nf=1 m=(1)
    PM1 (net02 c net07 VDD) g45p1svt w=(390n) l=45n nf=1 m=(1)
    mp0 (net02 a net07 VDD) g45p1svt w=(390n) l=45n nf=1 m=(1)
    PM0 (net07 b VDD VDD) g45p1svt w=(390n) l=45n nf=1 m=(1)
ends TH23X1

// SCLCell045/tb_TH23X1/schematic
V7 (c VSS) vsource dc=0 type=pulse val0=0 val1=1.2 period=25n delay=10n rise=100.0p fall=100.0p
V4 (a VSS) vsource dc=0 type=pulse val0=0 val1=1.2 period=100n delay=10n rise=100.0p fall=100.0p
V2 (s VSS) vsource type=pulse val0=0 val1=1.2 period=100n delay=20n rise=100.0p fall=100.0p
V6 (b VSS) vsource dc=0 type=pulse val0=0 val1=1.2 period=50n delay=10n rise=100.0p fall=100.0p
V5 (VSS 0) vsource dc=0 type=dc
V1 (VDD VSS) vsource dc=vdd type=dc
I10 (VDD VSS a b c q s) TH23X1
simulatorOptions options temp=27
tran tran stop=200n errpreset=moderate
dcOp dc
