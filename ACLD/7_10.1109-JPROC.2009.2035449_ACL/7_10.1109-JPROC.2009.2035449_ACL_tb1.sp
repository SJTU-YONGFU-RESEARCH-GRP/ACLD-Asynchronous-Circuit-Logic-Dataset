// Design: AscendNCLCell/testing
simulator lang=spectre
global 0
include "/home/yongfu/research-freepdk-library/Cadence45/TECH/GPDK045/gpdk045_v_6_0/gpdk045/../models/spectre/gpdk045.scs" section=mc

// AscendNCLCell/INCL1W111OF3X1/schematic
subckt INCL1W111OF3X1 a b c q VDD VSS
    MPI0 (VDD a pl00 VDD) g45p1svt w=390.00n l=45n ld=105n ls=105n m=1
    MPI2 (pl01 c q VDD) g45p1svt w=390.00n l=45n ld=105n ls=105n m=1
    MPI1 (pl00 b pl01 VDD) g45p1svt w=390.00n l=45n ld=105n ls=105n m=1
    MNI0 (q a VSS VSS) g45n1svt w=260.00n l=45n ld=105n ls=105n m=1
    MNI2 (q c VSS VSS) g45n1svt w=260.00n l=45n ld=105n ls=105n m=1
    MNI1 (q b VSS VSS) g45n1svt w=260.00n l=45n ld=105n ls=105n m=1
ends INCL1W111OF3X1

// AscendNCLCell/tb_INCL1W111OF3X1/schematic
I1 (A B C Q) INCL1W111OF3X1
V5 (VSS 0) vsource dc=0 type=dc
V1 (VDD VSS) vsource dc=vdd type=dc
V2 (C VSS) vsource dc=0 type=pulse val0=0 val1=1.2 period=25n delay=10n rise=100.0p fall=100.0p
V0 (B VSS) vsource dc=0 type=pulse val0=0 val1=1.2 period=50n delay=10n rise=100.0p fall=100.0p
V4 (A VSS) vsource dc=0 type=pulse val0=0 val1=1.2 period=100n delay=10n rise=100.0p fall=100.0p
simulatorOptions options temp=27
tran tran stop=200n errpreset=moderate
dcOp dc
